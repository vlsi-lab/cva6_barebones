// Copyright 2026 Federico Runco (federico.runco@gmail.com)
// SPDX-License-Identifier: Apache-2.0 WITH SHL-2.1
// 
// Licensed under the Solderpad Hardware License v2.1 (the “License”); 
// you may not use this file except in compliance with the License, or, 
// at your option, the Apache License version 2.0. You may obtain a copy 
// of the License at https://solderpad.org/licenses/SHL-2.1/
// 
// Unless required by applicable law or agreed to in writing, any work 
// distributed under the License is distributed on an “AS IS” BASIS, WITHOUT 
// WARRANTIES OR CONDITIONS OF ANY KIND, either express or implied. See the 
// License for the specific language governing permissions and limitations 
// under the License.

{
  name: "uart",
  clock_primary: "clk_i",
  reset_primary: "rst_ni",
  bus_interfaces: [
    {
      protocol: "reg_iface", 
      direction: "device" 
    }
  ],
  regwidth: "64",
  registers: [
    {
      name: "TX_DATA",
      desc: "TX Data register for the UART peripheral",
      swaccess: "wo",
      hwaccess: "hro",
      fields: [ { bits: "7:0" } ]
    },
    {
      name: "RX_DATA",
      desc: "RX Data register for the UART peripheral",
      swaccess: "ro",
      hwaccess: "hwo",
      fields: [ { bits: "7:0" } ]
    },
    {
      name: "CSREG",
      desc: "Control and status register for the UART peripheral",
      swaccess: "rw",
      hwaccess: "hrw",
      fields: [
        {
          bits: "0",
          name: "BUSY",
          desc: "TX busy"
        },
        {
          bits: "1",
          name: "START",
          desc: "TX start"
        },
        {
          bits: "2",
          name: "EMPTY",
          desc: "RX FIFO empty"
        },
        
      ]
    },
    {
      name: "DIVIDER",
      desc: "Divider for baud generation register",
      swaccess: "rw",
      hwaccess: "hrw",
      fields: [ { bits: "63:0" } ]
    },
  ]
}